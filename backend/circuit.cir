* auto-generated circuit
V_c_1779474477976_txmf7u B6 0 DC 6
R_c_1779474527073_5g3isa B4 B6 100
R_c_1779474531205_2icmvr B4 D4 0.00001
R_c_1779474534088_d6wd0j E4 E6 0.00001
R_GND_D4 D4 0 1e12
R_GND_E6 E6 0 1e12
R_GND_B4 B4 0 1e12
R_GND_B6 B6 0 1e12
R_GND_E4 E4 0 1e12
.model DIODE_MODEL    D (IS=1e-10 N=1.0  RS=1  BV=100)
.model LEDMODEL_RED   D (IS=1e-30 N=2.5  RS=3  BV=5)
.model LEDMODEL_GREEN D (IS=1e-40 N=3.0  RS=3  BV=5)
.model LEDMODEL_BLUE  D (IS=1e-50 N=3.5  RS=3  BV=5)
.model NPN_MODEL NPN (IS=1e-14 BF=150 VAF=100 IKF=0.3 RC=0.1)
.model PNP_MODEL PNP (IS=1e-14 BF=150 VAF=100 IKF=0.3 RC=0.1)
.model NPN_DARLINGTON NPN (IS=1e-14 BF=5000 VAF=100 IKF=0.3 RC=0.1)
.model PNP_DARLINGTON PNP (IS=1e-14 BF=5000 VAF=100 IKF=0.3 RC=0.1)
.options savecurrents

.control
op
print all

quit
.endc
.end
