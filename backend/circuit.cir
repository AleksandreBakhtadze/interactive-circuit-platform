* auto-generated circuit
V_c_1779833448796_oqfyqz C5 0 DC 6
R_c_1779833455193_n32v01 A5 C5 0.00001
R_c_1779833457203_1adi3p A3 A5 0.00001
R_c_1779833459888_wo71xk A3 C3 100
D_c_1779834013640_1jvr6t C3 0 LEDMODEL_RED
R_GND_C3 C3 0 1e12
R_GND_C5 C5 0 1e12
R_GND_A3 A3 0 1e12
R_GND_A5 A5 0 1e12
.model DIODE_MODEL    D (IS=1e-10 N=1.0  RS=1  BV=100)
.model LEDMODEL_RED   D (IS=1e-30 N=2.5  RS=3  BV=5)
.model LEDMODEL_GREEN D (IS=1e-40 N=3.0  RS=3  BV=5)
.model LEDMODEL_BLUE  D (IS=1e-50 N=3.5  RS=3  BV=5)
.model NPN_MODEL NPN (IS=1e-14 BF=150 VAF=100 IKF=0.3 RC=0.1)
.model PNP_MODEL PNP (IS=1e-14 BF=150 VAF=100 IKF=0.3 RC=0.1)
.model NPN_DARLINGTON NPN (IS=1e-14 BF=5000 VAF=100 IKF=0.3 RC=0.1)
.model PNP_DARLINGTON PNP (IS=1e-14 BF=5000 VAF=100 IKF=0.3 RC=0.1)
.options savecurrents

.control
op
print all

quit
.endc
.end
