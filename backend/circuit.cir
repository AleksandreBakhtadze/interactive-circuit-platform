* auto-generated circuit
V_c_1779295041715_1odegl A6 0 DC 6
V_c_1779295043490_hrz3v8 0 F6 DC 6
R_c_1779295055587_prayw5 A4 A6 1e12
R_c_1779295060572_v4mada A4 F6 100
R_GND_F6 F6 0 1e12
R_GND_A4 A4 0 1e12
R_GND_A6 A6 0 1e12
.model DIODE_MODEL    D (IS=1e-10 N=1.0  RS=1  BV=100)
.model LEDMODEL_RED   D (IS=1e-30 N=2.5  RS=3  BV=5)
.model LEDMODEL_GREEN D (IS=1e-40 N=3.0  RS=3  BV=5)
.model LEDMODEL_BLUE  D (IS=1e-50 N=3.5  RS=3  BV=5)
.model NPN_MODEL NPN (IS=1e-14 BF=150 VAF=100 IKF=0.3 RC=0.1)
.model PNP_MODEL PNP (IS=1e-14 BF=150 VAF=100 IKF=0.3 RC=0.1)
.model NPN_DARLINGTON NPN (IS=1e-14 BF=5000 VAF=100 IKF=0.3 RC=0.1)
.model PNP_DARLINGTON PNP (IS=1e-14 BF=5000 VAF=100 IKF=0.3 RC=0.1)
.options savecurrents

.control
op
print all

quit
.endc
.end
