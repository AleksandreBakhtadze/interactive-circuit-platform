* auto-generated circuit
V_ps1 FULL MID DC 6
V_ps2 MID 0 DC 6
R_sw FULL VCC 0.00001
R_pot_L NBASE 0 50.0
R_pot_R NBASE VCC 10000.0
R_rpull VCC PBASE 1000
R_rdrive NCOLL PBASE 1000
R_rfb LAMP NBASE 1000
Q_qn NCOLL NBASE 0 NPN_MODEL
Q_qp LAMP PBASE VCC PNP_MODEL
R_lamp LAMP 0 100
R_GND_NCOLL NCOLL 0 1e12
R_GND_NBASE NBASE 0 1e12
R_GND_VCC VCC 0 1e12
R_GND_PBASE PBASE 0 1e12
R_GND_MID MID 0 1e12
R_GND_LAMP LAMP 0 1e12
R_GND_FULL FULL 0 1e12
.model DIODE_MODEL    D (IS=3e-7 N=1.12 RS=2  BV=100)
.model LEDMODEL_RED   D (IS=9e-21 N=1.9  RS=55 BV=20)
.model LEDMODEL_GREEN D (IS=2e-21 N=2.0  RS=3  BV=20)
.model LEDMODEL_BLUE  D (IS=5e-22 N=2.2  RS=4  BV=20)
.model NPN_MODEL NPN (IS=1e-14 BF=150 VAF=100 IKF=0.3 RC=0.1)
.model PNP_MODEL PNP (IS=1e-14 BF=150 VAF=100 IKF=0.3 RC=0.1)
.model NPN_DARLINGTON NPN (IS=1e-14 BF=100000 VAF=100 IKF=0.3 RC=0.1)
.model PNP_DARLINGTON PNP (IS=1e-14 BF=100000 VAF=100 IKF=0.3 RC=0.1)
.options savecurrents

.control
nodeset v(vcc)=12.000000 v(pbase)=11.205710 v(mid)=6.000000 v(lamp)=11.904450 v(ncoll)=0.031886 v(nbase)=0.826479 v(full)=12.000000
op
print all

quit
.endc
.end
