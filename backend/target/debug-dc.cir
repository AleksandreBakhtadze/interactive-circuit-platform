* auto-generated circuit
V_ps1 A7 0 DC 6
V_ps2 0 E3 DC 6
C_cap1 E3 C5 10u
R_btn1 C5 A7 0.00001
R_r1 C5 C3 1000
D_led1 C3 E3 LEDMODEL_RED
R_GND_C3 C3 0 1e12
R_GND_C5 C5 0 1e12
R_GND_A7 A7 0 1e12
R_GND_E3 E3 0 1e12
.model DIODE_MODEL    D (IS=1e-10 N=1.0  RS=1  BV=100)
.model LEDMODEL_RED   D (IS=1e-30 N=2.5  RS=3  BV=5)
.model LEDMODEL_GREEN D (IS=1e-40 N=3.0  RS=3  BV=5)
.model LEDMODEL_BLUE  D (IS=1e-50 N=3.5  RS=3  BV=5)
.model NPN_MODEL NPN (IS=1e-14 BF=150 VAF=100 IKF=0.3 RC=0.1)
.model PNP_MODEL PNP (IS=1e-14 BF=150 VAF=100 IKF=0.3 RC=0.1)
.model NPN_DARLINGTON NPN (IS=1e-14 BF=5000 VAF=100 IKF=0.3 RC=0.1)
.model PNP_DARLINGTON PNP (IS=1e-14 BF=5000 VAF=100 IKF=0.3 RC=0.1)
.options savecurrents

.control
op
print all

quit
.endc
.end
