* auto-generated circuit
V_vcc vcc 0 DC 6
R_lamp1 vcc nc 100
Q_q1 nc nb 0 NPN_MODEL
R_switch1 vcc n1 0.00001
R_photo1 n1 n2 1000
R_rb n2 nb 10000
R_GND_n1 n1 0 1e12
R_GND_nb nb 0 1e12
R_GND_n2 n2 0 1e12
R_GND_nc nc 0 1e12
R_GND_vcc vcc 0 1e12
.model DIODE_MODEL    D (IS=1e-10 N=1.0  RS=1  BV=100)
.model LEDMODEL_RED   D (IS=1e-30 N=2.5  RS=3  BV=5)
.model LEDMODEL_GREEN D (IS=1e-40 N=3.0  RS=3  BV=5)
.model LEDMODEL_BLUE  D (IS=1e-50 N=3.5  RS=3  BV=5)
.model NPN_MODEL NPN (IS=1e-14 BF=150 VAF=100 IKF=0.3 RC=0.1)
.model PNP_MODEL PNP (IS=1e-14 BF=150 VAF=100 IKF=0.3 RC=0.1)
.model NPN_DARLINGTON NPN (IS=1e-14 BF=5000 VAF=100 IKF=0.3 RC=0.1)
.model PNP_DARLINGTON PNP (IS=1e-14 BF=5000 VAF=100 IKF=0.3 RC=0.1)
.options savecurrents

.control
op
print all

quit
.endc
.end
